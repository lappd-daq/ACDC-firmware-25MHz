[IBIS Ver]   4.1
[Comment Char] |_char
[File Name]   acdc-1v1.ibs
[File Rev]   1.0
[Date]   August 28, 2017
[Source]   Derived from cycloneIII_spice_model,rev 1.0, dated 11/02/07
   using HSPICE Y-2006.03
[Notes]   - The models are designated as "Correlated" and have been
   correlated against physical device operation.
   - This IBIS model is checked using IBISCHK v4.2.2
   There are no known errors and warnings reported.
   - There are no known limitations for this IBIS model release.
   - Contact point: Altera Corporation,
   http://www.altera.com/corporate/contact/con-index.html
   - This file is generated using Quartus II
   Version 16.0.0 Build 211 04/27/2016 SJ Standard Edition
   - Unused IOs which have been assigned as tri-stated inputs or
   as outputs driving any signal in Quartus II are represented
   by the NC.
   - Only general purpose and configuration I/O IBIS models are
   supported
   Revision History
   - v1.0
   - Initial Release of Cyclone IV IBIS models
   - v2.0
   - Added configuration pins IBIS models
   - C_comp values for different pin types
   When an IBIS model is assigned to different pin types in
   Cyclone III LS devices, the C_comp value will be different.
   Use the following C_comp values according to the pin types:
   Pin Type   C_comp
   Normal Column I/O   4.7pF
   Normal Row I/O   4.4pF
   Differential Row I/O   5.0pF
   *Note (1): These IBIS models are generated based on a
   pre-determined Quartus II default slew rate setting.
   For IBIS models with other slew rate settings,
   please contact Altera Corporation.
[Disclaimer]   Data is for modeling purposes only and is not guaranteed.
[Copyright]   Copyright (C) 1991-2016 Altera Corporation. All rights reserved.
[Component]   EP4CGX110DF27C7_acdc-1v1
[Manufacturer] Altera Corporation
[Package]
| RLC values are for 672 FBGA package
| variable  typ   min   max
R_pkg   304m   135m   432m
L_pkg   5.67nH   2.42nH   8.42nH
C_pkg   0.50pF   0.30pF   0.64pF
[Pin]  signal_name   model_name   R_pin   L_pin   C_pin
A10   USB_FD[1]   cmos33_cio_d2p
A11   FPGA_CLKOUT   cmos33_cio_d2
A12   USB_FD[2]   cmos33_cio_d2p
A13   USB_FD[3]   cmos33_cio_d2p
A14   CLK_IN_REF[4]   ttl25_cin_p
A15   PSEC_A_RD_CLK   ttl25_cio_r50
A16   PSEC_A_data[8]   ttl25_cin_p
A17   PSEC_A_data[7]   ttl25_cin_p
A18   PSEC_A_trig[2]   ttl25_cin_p
A19   PSEC_A_trig[0]   ttl25_cin_p
A2   JC_mode_sel   cmos33_cio_d2
A20   PSEC_A_data[0]   ttl25_cin_p
A21   PSEC_A_TokDECODE[0]   ttl25_cio_r50
A22   PSEC_A_ChanDECODE[1]  ttl25_cio_r50
A23   PSEC_A_RO_mon   ttl25_cin_p
A24   PSEC_A_RO_enable   ttl25_cio_r50
A25   PSEC_GLOBAL_trigSIGN  ttl25_cio_r50
A3   JC_LE   cmos33_cio_d2
A4   JC_MISO   cmos33_cin_p
A5   JC_MOSI   cmos33_cio_d2
A6   USB_PA[0]   cmos33_cio_d2p
A7   USB_PA[4]   cmos33_cio_d2p
A8   USB_PA[5]   cmos33_cio_d2p
A9   USB_FD[0]   cmos33_cio_d2p
AA10   VCCIO3   POWER
AA11   VCCIO3   POWER
AA12   VCCIO3   POWER
AA13   VCCIO3   POWER
AA14   VCCIO3   POWER
AA15   PSEC_E_data[1]   ttl25_cin_p
AA16   VCCIO4   POWER
AA17   GPIO_1v2[16]   ttl25_cio_r50p
AA18   VCCIO4   POWER
AA19   VCCIO4   POWER
AA20   PSEC_D_ChanDECODE[2]  ttl25_cio_r50
AA21   CLK_OUT_1v2[2]   ttl25_cio_r50
AA22   user_reserve_7   ttl25_cio_r50
AA23   PSEC_D_trig[3]   ttl25_rdin_p
AA24   PSEC_D_trig[5]   ttl25_rdin_p
AA25   PSEC_D_data[8]   ttl25_rdin_p
AA26   PSEC_D_data[9]   ttl25_rdin_p
AA3   VCCL_GXB   POWER
AA4   VCCL_GXB   POWER
AA7   GPIO_2v5[4]   ttl25_cio_r50p
AA8   GPIO_2v5[8]   ttl25_cio_r50p
AA9   GPIO_2v5[14]   ttl25_cio_r50p
AB1   GND   GND
AB10   GND   GND
AB11   GPIO_2v5[26]   ttl25_cio_r50p
AB12   GPIO_2v5[0]   ttl25_cio_r50p
AB13   GND   GND
AB14   user_reserve_4   ttl25_cio_r50
AB15   PSEC_E_data[0]   ttl25_cin_p
AB16   GND   GND
AB17   VCCIO4   POWER
AB18   user_reserve_5   ttl25_cio_r50
AB19   GND   GND
AB2   GND   GND
AB20   PSEC_D_RO_mon   ttl25_cin_p
AB21   CLK_OUT_1v2[3]   ttl25_cio_r50
AB22   GND   GND
AB23   PSEC_D_trig[1]   ttl25_rdin_p
AB24   PSEC_D_trig[4]   ttl25_rdin_p
AB25   GND   GND
AB26   PSEC_D_data[6]   ttl25_rdin_p
AB5   CLK_OUT_2v5[0]   ttl25_cio_r50
AB7   init_done   ttl25_cio_r50
AB8   GPIO_2v5[9]   ttl25_cio_r50p
AB9   GPIO_2v5[5]   ttl25_cio_r50p
AC10   GPIO_2v5[19]   ttl25_cio_r50p
AC11   GPIO_2v5[27]   ttl25_cio_r50p
AC12   GPIO_2v5[2]   ttl25_cio_r50p
AC14   PSEC_E_TokDECODE[0]   ttl25_cio_r50
AC15   PSEC_E_EXT_trig   ttl25_cio_r50
AC16   PSEC_E_data[4]   ttl25_cin_p
AC17   PSEC_E_trig[2]   ttl25_cin_p
AC18   PSEC_E_data[7]   ttl25_cin_p
AC19   PSEC_E_data[11]   ttl25_cin_p
AC2   GND   GND
AC20   user_reserve_6   ttl25_cio_r50
AC21   PSEC_E_TOKin[1]   ttl25_cio_r50
AC22   PSEC_D_TokDECODE[2]   ttl25_cio_r50
AC23   PSEC_D_trig[2]   ttl25_rdin_p
AC24   PSEC_D_data[4]   ttl25_rdin_p
AC25   PSEC_D_data[3]   ttl25_rdin_p
AC26   PSEC_D_data[5]   ttl25_rdin_p
AC3   VCCA_GXB   POWER
AC4   CLK_OUT_2v5[2]   ttl25_cio_r50
AC5   CLK_OUT_2v5[1]   ttl25_cio_r50
AC6   GPIO_2v5[11]   ttl25_cio_r50p
AC8   GPIO_2v5[10]   ttl25_cio_r50p
AC9   GPIO_2v5[15]   ttl25_cio_r50p
AD1   GND   GND
AD10   GPIO_2v5[20]   ttl25_cio_r50p
AD11   user_reserve_59   ttl25_cio_r50
AD12   GPIO_2v5[21]   ttl25_cio_r50p
AD14   PSEC_E_TokDECODE[1]   ttl25_cio_r50
AD15   PSEC_E_clearADC   ttl25_cio_r50
AD16   PSEC_E_data[3]   ttl25_cin_p
AD17   PSEC_E_trig[1]   ttl25_cin_p
AD18   PSEC_E_trig[5]   ttl25_cin_p
AD19   PSEC_E_data[10]   ttl25_cin_p
AD2   VCCL_GXB   POWER
AD20   PSEC_E_DLLreset   ttl25_cio_r50
AD21   PSEC_E_RD_CLK   ttl25_cio_r50
AD22   PSEC_D_TOKin[0]   ttl25_cio_r50
AD23   PSEC_D_ADClatch   ttl25_cio_r50
AD24   PSEC_D_clearADC   ttl25_cio_r50
AD25   PSEC_D_data[1]   ttl25_rdin_p
AD26   PSEC_D_trig[0]   ttl25_rdin_p
AD3   CLK_OUT_2v5[4]   ttl25_cio_r50
AD4   CLK_OUT_2v5[3]   ttl25_cio_r50
AD9   GPIO_2v5[16]   ttl25_cio_r50p
AE1   lvds_tx_out[0]   lvds25_co_e3r
AE11   GPIO_2v5[28]   ttl25_cio_r50p
AE12   GND   GND
AE14   PSEC_E_TokDECODE[2]   ttl25_cio_r50
AE15   PSEC_E_ADClatch   ttl25_cio_r50
AE16   GND   GND
AE17   PSEC_E_data[5]   ttl25_cin_p
AE18   PSEC_E_trig[4]   ttl25_cin_p
AE19   PSEC_E_data[9]   ttl25_cin_p
AE2   lvds_tx_out[0](n)   lvds25_co_e3r
AE20   GND   GND
AE21   PSEC_E_trigCLEAR   ttl25_cio_r50
AE22   PSEC_D_ChanDECODE[0]  ttl25_cio_r50
AE23   PSEC_D_TokDECODE[0]   ttl25_cio_r50
AE24   GND   GND
AE25   PSEC_D_data[0]   ttl25_rdin_p
AE26   PSEC_D_data[2]   ttl25_rdin_p
AE3   CLK_OUT_2v5[5]   ttl25_cio_r50
AE4   GND   GND
AE5   lvds_rx_in[0]   lvds25_cin
AE6   lvds_rx_in[0](n)   lvds25_cin
AE7   GPIO_2v5[7]   ttl25_cio_r50p
AE8   GND   GND
AE9   lvds_rx_in[1]   lvds25_cin
AF11   lvds_rx_in[2]   lvds25_cin
AF12   lvds_rx_in[2](n)   lvds25_cin
AF13   PSEC_E_DIout   ttl25_cin_p
AF15   PSEC_E_TOKin[0]   ttl25_cio_r50
AF16   PSEC_E_data[2]   ttl25_cin_p
AF17   PSEC_E_trig[0]   ttl25_cin_p
AF18   PSEC_E_trig[3]   ttl25_cin_p
AF19   PSEC_E_data[8]   ttl25_cin_p
AF2   lvds_tx_out[1]   lvds25_co_e3r
AF20   PSEC_E_overflow   ttl25_cin_p
AF21   PSEC_E_rampSTART   ttl25_cio_r50
AF22   PSEC_D_ChanDECODE[1]  ttl25_cio_r50
AF23   PSEC_D_TokDECODE[1]   ttl25_cio_r50
AF24   PSEC_D_RO_enable   ttl25_cio_r50
AF25   PSEC_D_EXT_trig   ttl25_cio_r50
AF3   lvds_tx_out[1](n)   lvds25_co_e3r
AF4   lvds_tx_out[2]   lvds25_co_e3r
AF5   lvds_tx_out[2](n)   lvds25_co_e3r
AF6   GPIO_2v5[3]   ttl25_cio_r50p
AF7   lvds_tx_out[3]   lvds25_co_e3r
AF8   lvds_tx_out[3](n)   lvds25_co_e3r
AF9   lvds_rx_in[1](n)   lvds25_cin
B1   JC_powerdown   cmos33_cio_d2
B10   GPIO_3v3[7]   cmos33_cio_d2p
B11   USB_FD[4]   cmos33_cio_d2p
B12   GND   GND
B13   USB_CTL2   cmos33_cio_d2p
B14   PSEC_A_DIout   ttl25_cin_p
B15   PSEC_A_rampSTART   ttl25_cio_r50
B16   GND   GND
B17   PSEC_A_data[9]   ttl25_cin_p
B18   PSEC_A_trig[3]   ttl25_cin_p
B19   PSEC_A_data[3]   ttl25_cin_p
B2   JC_pll_lock   cmos33_cin_p
B20   GND   GND
B21   PSEC_A_ADClatch   ttl25_cio_r50
B22   PSEC_A_ChanDECODE[0]  ttl25_cio_r50
B23   PSEC_A_ChanDECODE[2]  ttl25_cio_r50
B24   GND   GND
B25   PSEC_B_TOKin[1]   ttl25_rdio_r50
B26   PSEC_B_trigCLEAR   ttl25_rdio_r50
B3   GND   GND
B4   GPIO_3v3[0]   cmos33_cio_d2p
B5   GPIO_3v3[1]   cmos33_cio_d2p
B6   USB_PA[1]   cmos33_cio_d2p
B7   USB_PA[3]   cmos33_cio_d2p
B8   GND   GND
B9   USB_PA[6]   cmos33_cio_d2p
C1   DAC_1_clr_n   cmos33_cio_d2
C10   USB_PA[7]   cmos33_cio_d2p
C11   GPIO_3v3[9]   cmos33_cio_d2p
C12   USB_FD[6]   cmos33_cio_d2p
C13   USB_CTL1   cmos33_cio_d2p
C14   PSEC_A_DLLreset   ttl25_cio_r50
C15   PSEC_A_trigCLEAR   ttl25_cio_r50
C16   PSEC_A_overflow   ttl25_cin_p
C17   PSEC_A_data[10]   ttl25_cin_p
C18   PSEC_A_trig[4]   ttl25_cin_p
C19   PSEC_A_data[4]   ttl25_cin_p
C2   JC_ref_sel   cmos33_cio_d2
C20   PSEC_A_data[1]   ttl25_cin_p
C21   PSEC_A_EXT_trig   ttl25_cio_r50
C22   PSEC_A_TokDECODE[1]   ttl25_cio_r50
C23   PSEC_A_TOKin[0]   ttl25_cio_r50
C24   PSEC_B_rampSTART   ttl25_rdio_r50
C25   PSEC_B_DLLreset   ttl25_rdio_r50
C26   PSEC_B_RD_CLK   ttl25_rdio_r50
C3   DAC_1_miso   cmos33_cin_p
C4   DAC_1_cs   cmos33_cio_d2
C5   JC_pll_rst   cmos33_cio_d2
C6   GPIO_3v3[2]   cmos33_cio_d2p
C7   USB_PA[2]   cmos33_cio_d2p
C8   DAC_0_cs   cmos33_cio_d2
C9   GPIO_3v3[4]   cmos33_cio_d2p
D1   JC_AUXOUT   cmos33_cin_p
D10   USB_FD[5]   cmos33_cio_d2p
D11   user_reserve_2   cmos33_cio_d2
D12   GPIO_3v3[12]   cmos33_cio_d2p
D13   USB_FD[8]   cmos33_cio_d2p
D14   user_reserve_3   cmos33_cio_d2
D15   PSEC_A_TOKin[1]   ttl25_cio_r50
D16   user_reserve_18   ttl25_cio_r50
D17   PSEC_A_data[11]   ttl25_cin_p
D18   PSEC_A_data[6]   ttl25_cin_p
D19   PSEC_A_data[5]   ttl25_cin_p
D2   JC_SCLK   cmos33_cio_d2
D20   PSEC_A_data[2]   ttl25_cin_p
D21   PSEC_A_clearADC   ttl25_cio_r50
D22   PSEC_A_TokDECODE[2]   ttl25_cio_r50
D23   user_reserve_16   ttl25_cio_r50
D24   PSEC_GLOBAL_FREQsel   ttl25_rdio_r50
D25   PSEC_B_overflow   ttl25_rdin_p
D26   PSEC_B_data[11]   ttl25_rdin_p
D3   DAC_1_mosi   cmos33_cio_d2
D4   MClk   cmos33_cio_d2
D5   serial_flash:inst8|a  ttl25_cio_d16f
D6   serial_flash:inst8|a  ttl25_cin
D7   SMA_trig   cmos33_cin_p
D8   DAC_0_mosi   cmos33_cio_d2
D9   GPIO_3v3[5]   cmos33_cio_d2p
E1   DAC_0_clr_n   cmos33_cio_d2
E10   VCCIO8   POWER
E11   GPIO_3v3[10]   cmos33_cio_d2p
E12   USB_FD[7]   cmos33_cio_d2p
E13   USB_CTL0   cmos33_cio_d2p
E14   USB_FD[9]   cmos33_cio_d2p
E15   GPIO_1v2[1]   ttl25_cio_r50p
E16   GPIO_1v2[0]   ttl25_cio_r50p
E17   user_reserve_19   ttl25_cio_r50
E18   PSEC_A_trig[5]   ttl25_cin_p
E19   PSEC_A_trig[1]   ttl25_cin_p
E2   DAC_1_sclk   cmos33_cio_d2
E20   user_reserve_20   ttl25_cio_r50
E21   CLK_OUT_1v2[1]   ttl25_cio_r50
E22   CLK_OUT_1v2[0]   ttl25_cio_r50
E23   user_reserve_17   ttl25_cio_r50
E24   PSEC_B_data[10]   ttl25_rdin_p
E25   PSEC_B_data[9]   ttl25_rdin_p
E26   PSEC_B_data[8]   ttl25_rdin_p
E3   GND   GND
E4   GND   GND
E6   serial_flash:inst8|a  ttl25_cio_d16f
E7   DAC_0_sclk   cmos33_cio_d2
E8   GPIO_3v3[3]   cmos33_cio_d2p
E9   user_reserve_1   cmos33_cio_d2
F1   GND   GND
F10   GND   GND
F11   VCCIO8   POWER
F12   GND   GND
F13   VCCIO8   POWER
F14   VCCIO8   POWER
F15   GPIO_1v2[2]   ttl25_cio_r50p
F16   VCCIO7   POWER
F17   GND   GND
F18   VCCIO7   POWER
F19   GND   GND
F2   GND   GND
F20   VCCIO7   POWER
F21   user_reserve_22   ttl25_rdio_r50
F22   GND   GND
F23   PSEC_B_trig[5]   ttl25_rdin_p
F24   PSEC_B_trig[4]   ttl25_rdin_p
F25   GND   GND
F26   PSEC_B_trig[3]   ttl25_rdin_p
F5   altera_reserved_tms   ttl33_rin
F6   serial_flash:inst8|a  ttl25_cio_d16f
F7   GND   GND
F8   DAC_0_miso   cmos33_cin_p
F9   VCCIO8   POWER
G10   GPIO_3v3[8]   cmos33_cio_d2p
G11   USB_FD[12]   cmos33_cio_d2p
G12   VCCIO8   POWER
G13   GND   GND
G14   GPIO_1v2[3]   ttl25_cio_r50p
G15   GPIO_1v2[4]   ttl25_cio_r50p
G16   VCCIO7   POWER
G17   GPIO_1v2[5]   ttl25_cio_r50p
G18   VCCIO7   POWER
G19   VCCIO7   POWER
G21   VCCD_PLL   POWER
G22   PSEC_B_trig[2]   ttl25_rdin_p
G23   user_reserve_24   ttl25_rio_r50
G24   PSEC_B_data[7]   ttl25_rdin_p
G25   PSEC_B_data[6]   ttl25_rdin_p
G26   PSEC_B_data[5]   ttl25_rdin_p
G3   GND   GND
G4   GND   GND
G5   VCCL_GXB   POWER
G6   altera_reserved_tdi   ttl33_rin
G7   VCCIO9   POWER
G8   altera_reserved_tck   ttl33_rin
G9   USB_FD[10]   cmos33_cio_d2p
H1   GND   GND
H10   USB_FD[11]   cmos33_cio_d2p
H11   GPIO_3v3[11]   cmos33_cio_d2p
H12   USB_FD[13]   cmos33_cio_d2p
H13   USB_WAKEUP_n   cmos33_cin_p
H14   GPIO_1v2[10]   ttl25_cio_r50p
H15   GPIO_1v2[9]   ttl25_cio_r50p
H16   GPIO_1v2[8]   ttl25_cio_r50p
H17   GPIO_1v2[7]   ttl25_cio_r50p
H18   GPIO_1v2[6]   ttl25_cio_r50p
H19   GND   GND
H2   GND   GND
H20   VCCA   POWER
H21   VCCIO6   POWER
H22   PSEC_B_data[4]   ttl25_rdin_p
H23   PSEC_B_trig[1]   ttl25_rdin_p
H24   PSEC_B_trig[0]   ttl25_rdin_p
H25   PSEC_B_data[3]   ttl25_rdin_p
H26   PSEC_B_data[2]   ttl25_rdin_p
H5   VCCL_GXB   POWER
H6   VCCA   POWER
H8   altera_reserved_tdo   2p5_o_tdo
H9   GPIO_3v3[6]   cmos33_cio_d2p
J10   VCCINT   POWER
J11   USB_RDY1   cmos33_cio_d2
J12   USB_RDY0   cmos33_cio_d2
J13   USB_FD[14]   cmos33_cio_d2p
J14   USB_IFCLK   cmos33_cin_p
J15   GPIO_1v2[11]   ttl25_cio_r50p
J16   GPIO_1v2[12]   ttl25_cio_r50p
J17   GPIO_1v2[13]   ttl25_cio_r50p
J18   GPIO_1v2[14]   ttl25_cio_r50p
J19   GPIO_1v2[15]   ttl25_cio_r50p
J20   user_reserve_21   ttl25_rdio_r50
J21   VCCIO6   POWER
J22   GND   GND
J23   PSEC_B_data[1]   ttl25_rdin_p
J24   user_reserve_23   ttl25_rio_r50
J25   PSEC_B_data[0]   ttl25_rdin_p
J26   PSEC_B_EXT_trig   ttl25_rdio_r50
J3   GND   GND
J4   GND   GND
J5   VCCH_GXB   POWER
J6   VCCD_PLL   POWER
J8   GND   GND
J9   VCC_CLKIN8B   POWER
K1   GND   GND
K11   GND   GND
K12   USB_FD[15]   cmos33_cio_d2p
K13   USB_CLKOUT   cmos33_cin_p
K14   VCC_CLKIN8A   POWER
K15   GND   GND
K16   VCCINT   POWER
K17   GND   GND
K18   VCCINT   POWER
K19   PSEC_B_TokDECODE[2]   ttl25_rdio_r50
K2   GND   GND
K20   PSEC_B_TokDECODE[1]   ttl25_rdio_r50
K21   PSEC_B_TokDECODE[0]   ttl25_rdio_r50
K22   PSEC_B_TOKin[0]   ttl25_rdio_r50
K23   PSEC_B_RO_enable   ttl25_rdio_r50
K24   PSEC_B_ADClatch   ttl25_rdio_r50
K25   GND   GND
K26   PSEC_B_clearADC   ttl25_rdio_r50
K5   VCCA_GXB   POWER
K7   VCCA   POWER
K8   VCCINT   POWER
L11   VCCINT   POWER
L12   GND   GND
L13   VCCINT   POWER
L16   GND   GND
L17   VCCINT   POWER
L18   GND   GND
L19   PSEC_B_ChanDECODE[2]  ttl25_rdio_r50
L20   VCCIO6   POWER
L21   PSEC_B_ChanDECODE[1]  ttl25_rdio_r50
L22   PSEC_B_ChanDECODE[0]  ttl25_rdio_r50
L23   PSEC_B_RO_mon   ttl25_rdin_p
L24   PSEC_C_TOKin[1]   ttl25_rdio_r50
L25   PSEC_C_trigCLEAR   ttl25_rdio_r50
L26   PSEC_C_RD_CLK   ttl25_rdio_r50
L3   GND   GND
L4   GND   GND
L5   VCCL_GXB   POWER
L6   VCCD_PLL   POWER
L7   VCCINT   POWER
L8   GND   GND
M1   GND   GND
M10   VCCINT   POWER
M11   GND   GND
M12   VCCINT   POWER
M13   GND   GND
M14   VCCINT   POWER
M15   GND   GND
M16   VCCINT   POWER
M17   GND   GND
M18   VCCINT   POWER
M19   PSEC_C_rampSTART   ttl25_rdio_r50
M2   GND   GND
M20   VCCIO6   POWER
M21   GND   GND
M22   PSEC_C_DLLreset   ttl25_rdio_r50
M23   user_reserve_25   ttl25_rio_r50
M24   PSEC_C_overflow   ttl25_rdin_p
M25   PSEC_C_data[11]   ttl25_rdin_p
M26   PSEC_C_data[10]   ttl25_rdin_p
M5   VCCH_GXB   POWER
M6   VCCD_PLL   POWER
M7   GND   GND
M8   VCCINT   POWER
M9   GND   GND
N10   GND   GND
N11   VCCINT   POWER
N12   GND   GND
N13   VCCINT   POWER
N14   GND   GND
N15   VCCINT   POWER
N16   GND   GND
N17   VCCINT   POWER
N18   GND   GND
N19   PSEC_C_trig[5]   ttl25_rdin_p
N20   PSEC_C_data[6]   ttl25_rdin_p
N21   VCCIO6   POWER
N22   PSEC_C_data[7]   ttl25_rdin_p
N23   PSEC_C_data[8]   ttl25_rdin_p
N24   PSEC_C_data[9]   ttl25_rdin_p
N25   PSEC_C_DIout   ttl25_rdin_p
N26   PSEC_B_DIout   ttl25_rdin_p
N3   GND   GND
N4   GND   GND
N5   VCCA_GXB   POWER
N7   VCCA   POWER
N8   GND   GND
N9   VCCINT   POWER
P1   GND   GND
P10   VCCINT   POWER
P11   GND   GND
P12   VCCINT   POWER
P13   GND   GND
P14   VCCINT   POWER
P15   GND   GND
P16   VCCINT   POWER
P17   GND   GND
P18   VCCINT   POWER
P19   PSEC_C_trig[0]   ttl25_rdin_p
P2   GND   GND
P20   PSEC_C_trig[3]   ttl25_rdin_p
P21   VCCIO5   POWER
P22   GND   GND
P23   PSEC_C_trig[4]   ttl25_rdin_p
P24   user_reserve_10   ttl25_rdio_r50
P25   GND   GND
P26   user_reserve_12   ttl25_rdin_p
P5   VCCL_GXB   POWER
P7   VCCA   POWER
P8   VCCINT   POWER
P9   GND   GND
R10   GND   GND
R11   VCCINT   POWER
R12   GND   GND
R13   VCCINT   POWER
R14   GND   GND
R15   VCCINT   POWER
R16   GND   GND
R17   VCCINT   POWER
R18   GND   GND
R19   PSEC_C_trig[1]   ttl25_rdin_p
R20   PSEC_C_data[3]   ttl25_rdin_p
R21   VCCIO5   POWER
R22   PSEC_C_data[4]   ttl25_rdin_p
R23   PSEC_C_trig[2]   ttl25_rdin_p
R24   user_reserve_13   ttl25_rio_r50
R25   PSEC_C_data[5]   ttl25_rdin_p
R26   PSEC_D_DIout   ttl25_rdin_p
R3   GND   GND
R4   GND   GND
R5   VCCH_GXB   POWER
R6   VCCD_PLL   POWER
R7   VCCINT   POWER
R8   GND   GND
R9   VCCINT   POWER
T1   GND   GND
T11   GND   GND
T12   VCCINT   POWER
T13   GND   GND
T16   VCCINT   POWER
T17   GND   GND
T18   VCCINT   POWER
T19   PSEC_C_TokDECODE[1]   ttl25_rdio_r50
T2   GND   GND
T20   VCCIO5   POWER
T21   PSEC_C_ADClatch   ttl25_rdio_r50
T22   PSEC_C_EXT_trig   ttl25_rdio_r50
T23   PSEC_C_clearADC   ttl25_rdio_r50
T24   PSEC_C_data[0]   ttl25_rdin_p
T25   PSEC_C_data[2]   ttl25_rdin_p
T26   PSEC_C_data[1]   ttl25_rdin_p
T5   VCCA_GXB   POWER
T6   VCCD_PLL   POWER
T7   GND   GND
T8   VCCINT   POWER
U11   VCCINT   POWER
U12   GPIO_2v5[29]   ttl25_cio_r50p
U13   VCCINT   POWER
U14   VCC_CLKIN3A   POWER
U15   VCCINT   POWER
U16   GPIO_1v2[21]   ttl25_cio_r50p
U17   VCCINT   POWER
U18   GPIO_1v2[18]   ttl25_cio_r50p
U19   PSEC_C_TokDECODE[0]   ttl25_rdio_r50
U20   VCCIO5   POWER
U21   GND   GND
U22   PSEC_C_TokDECODE[2]   ttl25_rdio_r50
U23   PSEC_C_TOKin[0]   ttl25_rdio_r50
U24   user_reserve_14   ttl25_rio_r50
U25   PSEC_C_ChanDECODE[1]  ttl25_rdio_r50
U26   PSEC_C_ChanDECODE[0]  ttl25_rdio_r50
U3   GND   GND
U4   GND   GND
U5   VCCL_GXB   POWER
U7   VCCA   POWER
U8   GND   GND
V1   GND   GND
V10   VCCINT   POWER
V12   GPIO_2v5[23]   ttl25_cio_r50p
V13   GPIO_2v5[22]   ttl25_cio_r50p
V16   PSEC_E_RO_enable   ttl25_cio_r50
V17   GPIO_1v2[20]   ttl25_cio_r50p
V18   GPIO_1v2[19]   ttl25_cio_r50p
V19   GPIO_1v2[17]   ttl25_cio_r50p
V2   GND   GND
V20   VCCIO5   POWER
V21   user_reserve_11   ttl25_rdio_r50
V22   PSEC_C_RO_enable   ttl25_rdio_r50
V23   PSEC_D_TOKin[1]   ttl25_rdio_r50
V24   PSEC_C_RO_mon   ttl25_rdin_p
V25   GND   GND
V26   PSEC_C_ChanDECODE[2]  ttl25_rdio_r50
V5   VCCH_GXB   POWER
V6   VCCD_PLL   POWER
V8   VCCINT   POWER
V9   VCC_CLKIN3B   POWER
W10   GPIO_2v5[17]   ttl25_cio_r50p
W11   GPIO_2v5[24]   ttl25_cio_r50p
W12   user_reserve_58   ttl25_cio_r50
W16   PSEC_E_RO_mon   ttl25_cin_p
W17   PSEC_E_ChanDECODE[0]  ttl25_cio_r50
W18   PSEC_E_ChanDECODE[1]  ttl25_cio_r50
W19   PSEC_E_ChanDECODE[2]  ttl25_cio_r50
W21   VCCA   POWER
W22   PSEC_D_overflow   ttl25_rdin_p
W23   user_reserve_15   ttl25_rio_r50
W24   PSEC_D_rampSTART   ttl25_rdio_r50
W25   PSEC_D_trigCLEAR   ttl25_rdio_r50
W26   PSEC_D_RD_CLK   ttl25_rdio_r50
W3   GND   GND
W4   GND   GND
W5   VCCA_GXB   POWER
W6   VCCA   POWER
W8   VCCIO3   POWER
W9   GPIO_2v5[12]   ttl25_cio_r50p
Y1   GND   GND
Y10   GPIO_2v5[18]   ttl25_cio_r50p
Y11   GPIO_2v5[25]   ttl25_cio_r50p
Y12   GPIO_2v5[6]   ttl25_cio_r50p
Y13   GPIO_2v5[13]   ttl25_cio_r50p
Y15   VCCIO4   POWER
Y16   GND   GND
Y17   PSEC_E_data[6]   ttl25_cin_p
Y18   GND   GND
Y19   VCCIO4   POWER
Y2   GND   GND
Y20   VCCD_PLL   POWER
Y21   user_reserve_8   ttl25_cio_r50
Y22   user_reserve_9   ttl25_rio_r50
Y23   PSEC_D_data[7]   ttl25_rin_p
Y24   PSEC_D_data[10]   ttl25_rdin_p
Y25   PSEC_D_data[11]   ttl25_rdin_p
Y26   PSEC_D_DLLreset   ttl25_rdio_r50
Y5   VCCL_GXB   POWER
Y8   GND   GND
Y9   GPIO_2v5[1]   ttl25_cio_r50p
[Diff Pin]  inv_pin  vdiff  tdelay_typ  tdelay_min  tdelay_max
AE5   AE6   0.1   NA   NA   NA
AE9   AF9   0.1   NA   NA   NA
AF11   AF12   0.1   NA   NA   NA
| Models and submodels in the file (16): 2p5_o_tdo (Output), cmos33_cin_p (Input), cmos33_cio_d2 (I/O), cmos33_cio_d2p (I/O), lvds25_cin (Input), lvds25_co_e3r (Output), ttl25_cin (Input), ttl25_cin_p (Input), ttl25_cio_d16f (I/O), ttl25_cio_r50 (I/O), ttl25_cio_r50p (I/O), ttl25_rdin_p (Input), ttl25_rdio_r50 (I/O), ttl25_rin_p (Input), ttl25_rio_r50 (I/O), ttl33_rin (Input)
